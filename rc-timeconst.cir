.title RC Time Constant Circuit
v1 0 1 dc 10
r1 0 2 3.3k
c1 1 2 47u ic=0
c2 1 2 22u ic=0
.tran 0.05 1 uic
.print tran v(1,2)
.end
