bjt biasing problem 1

Vcc 1 0 12
Rb 1 2 240k
Rc 1 3 2.2k
.model QMOD NPN
Q1 3 2 0 QMOD
.OP
.print v(3) v(2)
.end
