.title voltage divider biasing for bjt - independent of beta
r1 1 2 39k
r2 2 GND 3.9k
rc 1 3 10k
re 4 GND 1.5k
q1 3 2 4 mod1
.model mod1 npn
vcc 1 GND dc 22
.dc vcc 0 22 2
.print dc v(2) v(4)
.end
