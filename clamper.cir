clamper

V1 1 0 SIN(0 20 1kHz)
C 1 2 100nF
R 2 0 56k
.model diode D
D1 3 2 diode
Vb1 0 3 8.3
.CONTROL
tran 0.01m 5ms
plot V(1) V(2)

.endc
