.title hit and trial circuit
v1 1 0 sin(0 2 220)
.tran .1 5
.plot tran v(1)
.end
