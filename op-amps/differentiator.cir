.title differentiator circuit with op amp
.include LF356.MOD
XU1 3 2 7 4 6 LF356/NS
vs+ 7 0 5
vs- 4 0 -5
vin+ 3 0 0
r2 2 6 100k
c2 2 6 100p
c1 2 8 0.1u
r1 8 1 1k
vin- 1 0 PULSE(-1 1 0.01NS 1MS 1MS 0.01NS 2MS)
.tran 1M 10M
.plot tran v(1) v(6)
.end
