.title inverting comparator using op amps
.include LF356.MOD
XU1 3 2 7 4 6 LF356/NS
vin+ 3 0 0
vin- 2 0 SIN(0 2 220)
vs+ 7 0 5
vs- 4 0 -5
.tran 1m 10m
.plot tran v(6) v(2)
.end
