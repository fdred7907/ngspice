.title summing amplifier with op amp
.include LF356.MOD
XU1 3 2 7 4 6 LF356/NS
vin+ 3 0 0
r2 2 1 1k
r1 2 8 1k
r3 6 2 1k
v2 1 0 SIN(0 2 220)
v1 8 0 SIN(0 2 220)
.tran 1m 10m
.plot tran v(1) v(8) v(6)
.end
