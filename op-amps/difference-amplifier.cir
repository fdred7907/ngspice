.title difference amplifier using op amp
.include LF356.MOD
XU1 3 2 7 4 6 LF356/NS
r1 2 1 10k
r2 6 2 10k
r3 3 8 10k
r4 3 0 10k
v1 1 0 SIN(0 2 220)
v2 8 0 SIN(0 2 220)
.tran 1m 10m
.plot tran  v(1) v(8) v(6)
.end
