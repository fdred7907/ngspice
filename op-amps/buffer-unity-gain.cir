.title buffer unity gain op amp circuit
.include LF356.MOD
XU1 3 2 7 4 6 LF356/NS
vs+ 7 0 5
vs- 4 0 -5
r1 6 2 1k
vin+ 3 0 SIN(0 2 220)
.tran 1m 10m
.plot tran v(3) v(6)
.end
