.title inverting amplifier using op amp
.include LF356.MOD
XU1 3 2 7 4 6 LF356/NS
vin+ 3 0 0
vin- 1 0 SIN(0 2 220)
r1 1 2 10k
r2 2 6 10k
.tran 1m 10m
.plot tran v(1) v(6)
.end
