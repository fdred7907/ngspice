.title noninverting amplifier circuit with op amp
.include LF356.MOD
XU1 3 2 7 4 6 LF356/NS
vin+ 3 0 SIN(0 2 220)
r1 2 0 1k
r2 2 6 10k
.tran 1m 10m
.plot tran v(3) v(6)
.end
